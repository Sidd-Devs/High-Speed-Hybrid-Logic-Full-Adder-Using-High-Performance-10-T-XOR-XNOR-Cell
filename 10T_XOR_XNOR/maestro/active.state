ADE simulation setup
Test ramkushal_10T_XOR_XNOR_1: ramkushal/10T_XOR_XNOR/schematic, simulator spectre
  Models: /mnt/cadence_tools/gpdk090_v4.6/libs.oa22/gpdk090/../../models/spectre/gpdk090.scs[NN]
  Temperature: 27
  Stimulus Vdd!: voltage dc dc=1.8 srcType=dc
  Stimulus A: voltage pulse val0=0 val1=1.8 period=4n delay=0 srcType=pulse
  Stimulus B: voltage pulse val0=0 val1=1.8 period=2n delay=0 srcType=pulse
  Analysis tran: stop=20n
  Signals: /XOR, /XNOR, /A, /B
Run mode: Single Run, Sweeps and Corners
