ADE simulation setup
Run mode: Single Run, Sweeps and Corners
Tests:
  ramkushal_10T_XOR_XNOR_1: ramkushal/10T_XOR_XNOR/schematic, simulator spectre
